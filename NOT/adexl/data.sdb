ADE simulation setup
Run mode: Single Run, Sweeps and Corners
Tests:
  DIGITAL_PROJECT:NOT:1: DIGITAL_PROJECT/NOT/schematic, simulator spectre
