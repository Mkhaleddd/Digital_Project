ADE simulation setup
Run mode: Single Run, Sweeps and Corners
Tests:
  DIGITAL_PROJECT:FILTER2:1: DIGITAL_PROJECT/FILTER2/schematic, simulator spectre
    Outputs: clk; in0; in1; in2; in3; 0; 1; 2; 3; 4; 5; 6; 7
